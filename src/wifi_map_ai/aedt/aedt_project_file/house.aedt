# Ansys Electronics Desktop project, version 2023.2
materials:
  vacuum: permittivity=1
  pec: conductivity=1e+30
  Cement: permittivity=9.79796 conductivity=0.000153516 dielectric_loss_tangent=0.00316228

design EM_field_distribution (HFSS, SBR+, model units meter)
variables:
  paramX = 7
  paramY = -3.5
geometry:
  Box1 [Cement, not solved inside] = box(corner=(1.5meter, -1meter, 0meter), size=(-1meter, 0.1meter, 2.4meter))
  Box2 = box(corner=(1.5meter, -1meter, 0meter), size=(-0.1meter, 1meter, 2.4meter))
  Box3 = box(corner=(1.5meter, -0.1meter, 0meter), size=(-0.6meter, 0.1meter, 2.4meter))
  Box4 = box(corner=(-0.1meter, 0meter, 0meter), size=(-0.5meter, -0.1meter, 2.4meter))
  Box5 = box(corner=(1.5meter, -0.1meter, 0meter), size=(-0.1meter, 3.5meter, 2.4meter))
  Box6 = box(corner=(1.5meter, 3.4meter, 0meter), size=(-4.1meter, -0.1meter, 2.4meter))
  Box2.move(-2meter, 0meter, 0meter)
  Box1.move(0meter, -1.5meter, 0meter)
  Box7 = box(corner=(1.5meter, 0meter, 2.4meter), size=(-0.1meter, -2.5meter, -2.4meter))
  Box8 = box(corner=(-2.6meter, 3.4meter, 0meter), size=(0.1meter, -3.6meter, 2.4meter))
  Box9 = box(corner=(-0.5meter, 0meter, 2.4meter), size=(-2.1meter, -0.1meter, -2.4meter))
  Box2.move(-0.425meter, 0meter, 0meter)
  Box2_1 = Box2.duplicate_along_line(step=(-1.575meter, 0meter, 0meter), total=2)
  Box10 = box(corner=(-1.4meter, -1meter, 0meter), size=(0.4meter, 0.1meter, 2.4meter))
  Box10_1 = Box10.duplicate_along_line(step=(-1.1meter, 0meter, 0meter), total=2)
  Box1_1 = Box1.duplicate_along_line(step=(-1.7meter, 0meter, 0meter), total=2)
  Box5_1 = Box5.duplicate_along_line(step=(0meter, -5.8meter, 0meter), total=2)
  Box5_1_1 = Box5_1.duplicate_along_line(step=(-2.7meter, 0meter, 0meter), total=2)
  Box11 = box(corner=(-1.3meter, -5.9meter, 2.4meter), size=(2.8meter, 0.1meter, -2.4meter))
  Box10_2 = Box10.duplicate_along_line(step=(-0.3meter, -1.5meter, 0meter), total=2)
  Box10_1_1 = Box10_1.duplicate_along_line(step=(-0.3meter, -1.5meter, 0meter), total=2)
  Box5_1_1_1 = Box5_1_1.duplicate_along_line(step=(-1.6meter, 0meter, 0meter), total=2)
  Box10_1_2 = Box10_1.duplicate_along_line(step=(-0.5meter, 0meter, 0meter), total=2)
  Box10_1_1_1 = Box10_1_1.duplicate_along_line(step=(-0.3meter, 0meter, 0meter), total=2)
  Box12 = box(corner=(-3.8meter, -2.4meter, 0meter), size=(-2.2meter, -0.1meter, 2.4meter))
  Box5_1_1_1_1 = Box5_1_1_1.duplicate_along_line(step=(-3.1meter, 8.8817842e-16meter, 0meter), total=2)
  Box13 = box(corner=(-6meter, -5.9meter, 2.4meter), size=(4.7meter, 0.1meter, -2.4meter))
  Box8.unite(Box2_1)
  Box8_1 = Box8.duplicate_along_line(step=(-3.4meter, 0meter, 0meter), total=2)
  Box12_1 = Box12.duplicate_along_line(step=(0meter, 1.5meter, 0.1meter), total=2)
  Box14 = box(corner=(-6meter, 3.4meter, 2.4meter), size=(3.4meter, -0.1meter, -2.4meter))
  Box15 = box(corner=(-5.9meter, -2.4meter, 2.4meter), size=(-0.1meter, 1.5meter, -2.4meter))
  Box12_1.move(0meter, 0meter, -0.1meter)
  Box16 = box(corner=(-4meter, -2.5meter, 0meter), size=(-0.1meter, 0.3meter, 2.4meter))
  Box16_1 = Box16.duplicate_along_line(step=(0meter, 1.3meter, 0meter), total=2)
  Box17 [pec] = box(corner=(-6meter, 3.4meter, 0meter), size=(7.5meter, -9.3meter, -0.1meter))
  coordinate_system RelativeCS1 = origin=(1.5meter, -2meter, 0meter) x=(1meter, 0meter, 0meter) y=(0meter, 1meter, 0meter)
  Box7_Split1 = Box7.split(plane=ZX, keep=Both) in RelativeCS1
  Box7.move_faces(MoveAlongNormalFlag=true OffsetDistance=-0.2meter FacesToMove=Box1.face(#923)) in RelativeCS1
  Box7_Split1.move_faces(MoveAlongNormalFlag=true OffsetDistance=-0.6meter FacesToMove=Box1.face(5 of 5)) in RelativeCS1
  Box1.unite(Box2..Box10, Box10_1, Box1_1, Box5_1, Box5_1_1, Box11, Box10_2, Box10_1_1, Box5_1_1_1, Box10_1_2, Box10_1_1_1, Box12, Box5_1_1_1_1, Box13, Box8_1, Box12_1, Box14, Box15, Box16, Box16_1, Box7_Split1)
  Domain [pec, non-model] = object_from(Box17.face(+z))
  Domain.move(0meter, 0meter, 1meter) in RelativeCS1
  Box1_2 = Box1.copy()
  Domain.subtract(Box1_2)
  coordinate_system WiFi_Tx_Position = origin=(-paramX, paramY, 1meter) x=(1meter, 0meter, 0meter) y=(0meter, 1meter, 0meter) in RelativeCS1
  wDipole1_1 = component(wDipole1, Type="Wire Dipole" Unit=meter Sheet=6 MatchedPortImpedance=50ohm Representation="Far Field" Resonant_Frequency=5GHz Wire_Length=0.029979246meter)
  wDipole1_Footprint [non-model] = part_of(wDipole1_1) in WiFi_Tx_Position
  coordinate_system FieldSamples = origin=(-2.25meter, -1.25meter, 1meter) x=(1meter, 0meter, 0meter) y=(0meter, 1meter, 0meter)
  Box1_3 = Box1.copy()
  Box17.subtract(Box1_3)
boundaries and excitations:
  wDipole1_1_p1: Proxy Port Objects=wDipole1_Footprint DefinitionPortType=-3 NumModes=1 RenormalizeAllTerminals=false Modes{Mode1{CharImp=Zpi}}
setups:
  Setup1: HfssDriven ComputeFields RayDensityPerWavelength=4 MaxNumberOfBounces=5 RadiationSetup=15 RadiationSetupIsNearField PTDUTDSimulationSettings=None
    sweep Sweep: point 5GHz;
source amplitudes:
  wDipole1_1_p1:1: 1W 0deg
optimetrics:
  ParametricSetup1: Parametric Sim._Setups=[Setup1]
    sweep paramX: LIN 0.5 7 0.5
    sweep paramY: LIN -3.5 5 0.5
radiation setups:
  Rectangle1: Near Rectangle  Length=7.2meter Width=9meter LengthSamples=101 WidthSamples=101 CoordSystem=FieldSamples
